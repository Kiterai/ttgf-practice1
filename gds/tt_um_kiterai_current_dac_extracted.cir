* Extracted by KLayout with GF180MCU LVS runset on : 20/06/2026 04:50

* cell tt_um_kiterai_current_dac
* pin VGND
* pin ua[0]
* pin ui_in[0]
* pin ui_in[1]
* pin ui_in[2]
* pin ui_in[3]
.SUBCKT tt_um_kiterai_current_dac VGND ua[0] ui_in[0] ui_in[1] ui_in[2] ui_in[3]
* device instance $1 r0 *1 319.27,281.855 nfet_03v3
M$1 VGND VGND VGND VGND nfet_03v3 L=0.56U W=22.08U AS=9.7152P AD=9.7152P
+ PS=86.4U PD=86.4U
* device instance $3 r0 *1 323.87,281.855 nfet_03v3
M$3 ua[0] VGND VGND VGND nfet_03v3 L=0.56U W=3.68U AS=1.6192P AD=1.6192P
+ PS=14.4U PD=14.4U
* device instance $4 r0 *1 326.17,281.855 nfet_03v3
M$4 VGND \$19 ua[0] VGND nfet_03v3 L=0.56U W=0.92U AS=0.4048P AD=0.4048P
+ PS=3.6U PD=3.6U
* device instance $5 r0 *1 328.47,281.855 nfet_03v3
M$5 ua[0] \$20 VGND VGND nfet_03v3 L=0.56U W=0.92U AS=0.4048P AD=0.4048P
+ PS=3.6U PD=3.6U
* device instance $19 r0 *1 323.87,284.855 nfet_03v3
M$19 ua[0] ui_in[3] VGND VGND nfet_03v3 L=0.56U W=7.36U AS=3.2384P AD=3.2384P
+ PS=28.8U PD=28.8U
* device instance $21 r0 *1 328.47,284.855 nfet_03v3
M$21 ua[0] ui_in[0] VGND VGND nfet_03v3 L=0.56U W=0.92U AS=0.4048P AD=0.4048P
+ PS=3.6U PD=3.6U
* device instance $22 r0 *1 330.77,284.855 nfet_03v3
M$22 VGND ui_in[2] ua[0] VGND nfet_03v3 L=0.56U W=3.68U AS=1.6192P AD=1.6192P
+ PS=14.4U PD=14.4U
* device instance $29 r0 *1 328.47,286.355 nfet_03v3
M$29 ua[0] ui_in[1] VGND VGND nfet_03v3 L=0.56U W=1.84U AS=0.8096P AD=0.8096P
+ PS=7.2U PD=7.2U
* device instance $44 r0 *1 326.17,289.355 nfet_03v3
M$44 VGND \$45 ua[0] VGND nfet_03v3 L=0.56U W=0.46U AS=0.2024P AD=0.2024P
+ PS=1.8U PD=1.8U
* device instance $53 r0 *1 328.47,290.855 nfet_03v3
M$53 ua[0] \$51 VGND VGND nfet_03v3 L=0.56U W=0.46U AS=0.2024P AD=0.2024P
+ PS=1.8U PD=1.8U
* device instance $84 r0 *1 326.17,296.855 nfet_03v3
M$84 VGND \$66 ua[0] VGND nfet_03v3 L=0.56U W=0.92U AS=0.4048P AD=0.4048P
+ PS=3.6U PD=3.6U
* device instance $85 r0 *1 328.47,296.855 nfet_03v3
M$85 ua[0] \$68 VGND VGND nfet_03v3 L=0.56U W=0.92U AS=0.4048P AD=0.4048P
+ PS=3.6U PD=3.6U
.ENDS tt_um_kiterai_current_dac
